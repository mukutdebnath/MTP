// VerilogA for BTP_ahdl, PIPO_2b, veriloga

`include "constants.vams"
`include "disciplines.vams"

`define SIZE 7

module PIPO_7b(vclk, vin, vout);
input vclk;
electrical vclk;
input [`SIZE-1:0] vin;
electrical [`SIZE-1:0] vin;
output [`SIZE-1:0] vout;
electrical [`SIZE-1:0] vout;

parameter real setval = 0 from [0: 1];
parameter real vlogic_high = 1.2;
parameter real vlogic_low = 0;
parameter real vtrans_clk = 0.6;
parameter real vtrans = 0.6;
parameter real tdel = 30p;
parameter real trise = 30p;
parameter real tfall = 30p;

	integer x[`SIZE-1:0];

	analog begin
		@ (initial_step("static", "ac")) begin
			generate j (`SIZE-1, 0) begin
				x[j] = setval;
			end
		end

		@ (cross( V(vclk) - vtrans_clk, +1 )) begin
			generate j (`SIZE-1, 0) begin
				x[j] = V(vin[j]) > vtrans;
			end
		end

		generate j (`SIZE-1, 0) begin
			V(vout[j]) <+ transition( (x[j] ? vlogic_high : vlogic_low),
								 		tdel, trise, tfall );
		end

	end
endmodule
