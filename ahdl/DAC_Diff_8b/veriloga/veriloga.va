// VerilogA for BTP_ahdl, DAC_Diff_8b, veriloga

`include "constants.vams"
`include "disciplines.vams"

`define SIZE 8

module DAC_Diff_8b(vin, voutp, voutn);
input [`SIZE-1:0] vin;
electrical [`SIZE-1:0] vin;
output voutp, voutn;
electrical voutp, voutn;

parameter real vref = 1.2;
parameter real vlogic_high = 1.2;
parameter real vlogic_low = 0;
parameter real vtrans = 0.6;
parameter real tdel = 30p;
parameter real trise = 30p;
parameter real tfall = 30p;

	real out;

	analog begin
		out = 0;
		generate j (`SIZE-1, 0) begin
			out = out + ( (V(vin[j]) > vtrans) ? 2**j : 0 );
		end
		out = out - 2**(`SIZE - 1);
		out = out / 2**(`SIZE - 1);
		V(voutp) <+ transition(+out*vref, tdel, trise, tfall);
		V(voutn) <+ transition(-out*vref, tdel, trise, tfall);
	end
endmodule
